subckt AMP_CASCODE65_v1 IM IP OM OP T TN2 TP TP2 VDD VSS
    M13 (net022 IP net3 VSS) nch_lvt l=ln1 w=wn1*fn1 multi=1 nf=fn1 sigma=1
    M8  (net021 IM net3 VSS) nch_lvt l=ln1 w=wn1*fn1 multi=1 nf=fn1 sigma=1
    M14 (OM TN2 net021 VSS)  nch_lvt l=ln2 w=wn2*fn2 multi=1 nf=fn2 sigma=1
    M15 (OP TN2 net022 VSS)  nch_lvt l=ln2 w=wn2*fn2 multi=1 nf=fn2 sigma=1
    M7  (net3 T VSS VSS)     nch_lvt l=lnt w=wnt*fnt multi=1 nf=fnt sigma=1
    M10 (net024 TP VDD VDD)  pch_lvt l=lp2 w=wp2*fp2 multi=1 nf=fp2 sigma=1
    M9  (net023 TP VDD VDD)  pch_lvt l=lp2 w=wp2*fp2 multi=1 nf=fp2 sigma=1
    M12 (OP TP2 net023 VDD)  pch_lvt l=lp1 w=wp1*fp1 multi=1 nf=fp1 sigma=1
    M11 (OM TP2 net024 VDD)  pch_lvt l=lp1 w=wp1*fp1 multi=1 nf=fp1 sigma=1
ends AMP_CASCODE65_v1
