simulator lang=spectre
global 0
parameters D2S_NMOS_WIDTH D2S_NMOS_FINGER CML_BUFFER_WIDTH \
    CML_BUFFER_FINGER D2S_PMOS_WIDTH D2S_PMOS_FINGER

R8 (VDD CML_OUT_P VSS ) res lr=5u wr=2u multi=(5) m=1

R1 (VDD CML_OUT_N VSS ) res lr=5u wr=2u multi=(5) m=1

//Series configuration of R0
R0_1__dmy0  (CML_IN_P R0_1__dmy0 VSS ) res lr=6u wr=1u multi=(1) m=1
R0_2__dmy0  (R0_1__dmy0 R0_2__dmy0 VSS ) res lr=6u wr=1u multi=(1) \
        m=1
R0_3__dmy0  (R0_2__dmy0 R0_3__dmy0 VSS ) res lr=6u wr=1u multi=(1) \
        m=1
R0_4__dmy0  (R0_3__dmy0 R0_4__dmy0 VSS ) res lr=6u wr=1u multi=(1) \
        m=1
R0_5__dmy0  (R0_4__dmy0 VCM VSS ) res lr=6u wr=1u multi=(1) m=1
//End of R0

R2 (CLKP net156 VSS ) res lr=2u wr=2u multi=(6) m=1

R4 (CLKP net156 VSS ) res lr=2u wr=2u multi=(6) m=1

R5 (net156 CLKN VSS ) res lr=2u wr=2u multi=(6) m=1

//Series configuration of R6
R6_1__dmy0  (VCM R6_1__dmy0 VSS ) res lr=6u wr=1u multi=(1) m=1
R6_2__dmy0  (R6_1__dmy0 R6_2__dmy0 VSS ) res lr=6u wr=1u multi=(1) \
        m=1
R6_3__dmy0  (R6_2__dmy0 R6_3__dmy0 VSS ) res lr=6u wr=1u multi=(1) \
        m=1
R6_4__dmy0  (R6_3__dmy0 R6_4__dmy0 VSS ) res lr=6u wr=1u multi=(1) \
        m=1
R6_5__dmy0  (R6_4__dmy0 CML_IN_N VSS ) res lr=6u wr=1u multi=(1) m=1
//End of R6

R3 (net156 CLKN VSS ) res lr=2u wr=2u multi=(6) m=1

C4 (CLKP CML_IN_P) cap nr=80 lr=20u w=50n s=50n stm=1 spm=7 multi=1
C0 (CLKN CML_IN_N) cap nr=80 lr=20u w=50n s=50n stm=1 spm=7 multi=1
M6 (net161 I_CML_REF VSS VSS) nmos l=120.0n w=20u multi=1 nf=10 \
M5 (I_CML_REF I_CML_REF VSS VSS) nmos l=120.0n w=20u multi=1 nf=10 \
M4 (VSS I_CML_REF VSS VSS) nmos l=120.0n w=92.0u multi=1 nf=46 \
M1 (V_CUR_MIR CML_OUT_P VSS VSS) nmos l=30n \
        w=D2S_NMOS_WIDTH*D2S_NMOS_FINGER multi=1 nf=D2S_NMOS_FINGER \
M0 (OUT CML_OUT_N VSS VSS) nmos l=30n \
        w=D2S_NMOS_WIDTH*D2S_NMOS_FINGER multi=1 nf=D2S_NMOS_FINGER \
M25 (CML_OUT_P CML_IN_P V_GND VSS) nmos l=30n \
        w=CML_BUFFER_WIDTH*CML_BUFFER_FINGER multi=1 nf=CML_BUFFER_FINGER \
M12 (CML_OUT_N CML_IN_N V_GND VSS) nmos l=30n \
        w=CML_BUFFER_WIDTH*CML_BUFFER_FINGER multi=1 nf=CML_BUFFER_FINGER \
M29 (V_GND CML_BIAS VSS VSS) nmos l=120.0n w=120.00000u multi=1 \
        nf=60
M37 (CML_BIAS CML_BIAS VSS VSS) nmos l=120.0n w=20u multi=1 nf=10 \
M3 (VSS CML_BIAS VSS VSS) nmos l=120.0n w=52.0u multi=1 nf=26 \
M9 (VDD net161 VDD VDD) pmos l=120.0n w=32.0u multi=1 nf=16 \
M8 (net161 net161 VDD VDD) pmos l=120.0n w=20u multi=1 nf=10 \
M7 (CML_BIAS net161 VDD VDD) pmos l=120.0n w=20u multi=1 nf=10 \
M2 (V_CUR_MIR V_CUR_MIR VDD VDD) pmos l=30n \
        w=D2S_PMOS_WIDTH*D2S_PMOS_FINGER multi=1 nf=D2S_PMOS_FINGER \
M27 (OUT V_CUR_MIR VDD VDD) pmos l=30n \
        w=D2S_PMOS_WIDTH*D2S_PMOS_FINGER multi=1 nf=D2S_PMOS_FINGER \

simulatorOptions options reltol=1e-3 vabstol=1e-6 iabstol=1e-12 temp=27 \
    tnom=27 multithread=on nthreads=4 scalem=1.0 scale=1.0 gmin=1e-12 \
    rforce=1 maxnotes=5 maxwarns=5 digits=5 cols=80 pivrel=1e-3 \
    sensfile="../psf/sens.output" checklimitdest=psf
modelParameter info what=models where=rawfile
element info what=inst where=rawfile
outputParameter info what=output where=rawfile
designParamVals info what=parameters where=rawfile
primitives info what=primitives where=rawfile
subckts info what=subckts where=rawfile
saveOptions options save=allpub
