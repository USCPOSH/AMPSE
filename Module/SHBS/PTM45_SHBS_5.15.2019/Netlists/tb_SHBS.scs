// Design: POSH_TI_SAR_Parameterized/tb_bootstrap2
simulator lang=spectre
global 0
parameters dif_pair=520n c_s=1p switch=900n inv=180n fs=250M fin=20M
include "/home/qiaochuz/workarea_ee536a/Techfile_45nm.scs"

// POSH_TI_SAR_Parameterized/inverter/schematic
subckt inverter_schematic VDD VIN VOUT VSS
    M0 (VOUT VIN VSS VSS) nmos w=inv l=45n m=10
    M1 (VOUT VIN VDD VDD) pmos w=26/9*inv l=45n m=10
ends inverter_schematic

// POSH_TI_SAR_Parameterized/clk_doubler/schematic
subckt clk_doubler_schematic VDD VIN VOUT VSS
    C1 (VOUT net5) capacitor c=2.5p m=3 ic=0
    C0 (VOUTb VIN) capacitor c=2.5p m=3 ic=0
    M0 (VDD VOUTb VOUT VSS) nmos w=600.0n l=45n m=10
    M18 (VDD VOUT VOUTb VSS) nmos w=600.0n l=45n m=10
    I0 (VDD VIN net5 VSS) inverter_schematic
ends clk_doubler_schematic

// POSH_TI_SAR_Parameterized/bootstrap/schematic
subckt bootstrap_schematic OUT VDD VSS clk clkb clkb_high IN
    M10 (net01 clk IN VSS) nmos w=900n l=45n m=20
    M11 (net012 clk IN VSS) nmos w=900.0n l=45n m=40
    M6 (VSS clkb net011 VSS) nmos w=900.0n l=45n m=1
    M4 (OUT net011 IN VSS) nmos w=switch l=45n m=10
    M1q (net01 clkb VSS VSS) nmos w=900.0n l=45n m=50
    M0 (VDD clkb_high net8 VSS) nmos w=900.0n l=45n m=1
    C0 (net8 net01) capacitor c=20p ic=1.1
    M12 (IN clkb net01 VDD) pmos w=900n l=45n m=20
    M7 (IN clkb net012 VDD) pmos w=900.0n l=45n m=40
    M13 (net012 clk VDD VDD) pmos w=900.0n l=45n m=20
    M2 (net011 net012 net8 net8) pmos w=900n l=45n m=1
ends bootstrap_schematic

// POSH_TI_SAR_Parameterized/bootstrap_diff/schematic
subckt bootstrap_diff_schematic CLK CLKbar INN INP VDD VOUTN VOUTP VSS
    I18 (VDD CLK net6 VSS) clk_doubler_schematic
    I19 (VDD CLK net5 VSS) clk_doubler_schematic
    I14 (VOUTP VDD VSS CLK CLKbar net6 INP) bootstrap_schematic
    I10 (VOUTN VDD VSS CLK CLKbar net5 INN) bootstrap_schematic
ends bootstrap_diff_schematic

// POSH_TI_SAR_Parameterized/tb_bootstrap2/schematic
M0 (VSS VOUTP VDD VDD) pmos w=dif_pair l=45n m=5
M1 (VSS VOUTN VDD VDD) pmos w=dif_pair l=45n m=5
C1 (VOUTN 0) capacitor c=c_s ic=0
C2 (VOUTP 0) capacitor c=c_s ic=0
V1 (VSS 0) vsource dc=0 type=dc
V0 (VDD 0) vsource dc=1.1 type=dc
V16 (CLKbar 0) vsource type=pulse val0=1.1 val1=0 period=1/fs delay=1/(2*fs) width=1/(2*fs)
V15 (CLK 0) vsource type=pulse val0=0 val1=1.1 period=1/fs delay=1/(2*fs) width=1/(2*fs)
V12 (INN 0) vsource dc=950.00m mag=1 phase=180 type=sine ampl=500.00m sinephase=180 freq=fin
V11 (INP 0) vsource dc=950.00m mag=1 type=sine ampl=500.00m sinephase=0 freq=fin
I21 (CLK CLKbar INN INP VDD VOUTN VOUTP VSS) bootstrap_diff_schematic
simulatorOptions options temp=27
tran tran stop=1u errpreset=conservative
