// Design: POSH_TI_SAR_Parameterized/bootstrap_diff
simulator lang=spectre
global 0
parameters inv switch

// POSH_TI_SAR_Parameterized/inverter/schematic
subckt inverter VDD VIN VOUT VSS
    M0 (VOUT VIN VSS VSS) nmos w=inv l=45n m=10
    M1 (VOUT VIN VDD VDD) pmos w=26/9*inv l=45n m=10
ends inverter

// POSH_TI_SAR_Parameterized/clk_doubler/schematic
subckt clk_doubler VDD VIN VOUT VSS
    C1 (VOUT net5) capacitor c=2.5p m=3 ic=0
    C0 (VOUTb VIN) capacitor c=2.5p m=3 ic=0
    M0 (VDD VOUTb VOUT VSS) nmos w=600.0n l=45n m=10
    M18 (VDD VOUT VOUTb VSS) nmos w=600.0n l=45n m=10
    I0 (VDD VIN net5 VSS) inverter
ends clk_doubler

// POSH_TI_SAR_Parameterized/bootstrap/schematic
subckt bootstrap OUT VDD VSS clk clkb clkb_high IN
    M10 (net01 clk IN VSS) nmos w=900n l=45n m=20
    M11 (net012 clk IN VSS) nmos w=900.0n l=45n m=40
    M6 (VSS clkb net011 VSS) nmos w=900.0n l=45n m=1
    M4 (OUT net011 IN VSS) nmos w=switch l=45n m=10
    M1q (net01 clkb VSS VSS) nmos w=900.0n l=45n m=50
    M0 (VDD clkb_high net8 VSS) nmos w=900.0n l=45n m=1
    C0 (net8 net01) capacitor c=20p ic=1.1
    M12 (IN clkb net01 VDD) pmos w=900n l=45n m=20
    M7 (IN clkb net012 VDD) pmos w=900.0n l=45n m=40
    M13 (net012 clk VDD VDD) pmos w=900.0n l=45n m=20
    M2 (net011 net012 net8 net8) pmos w=900n l=45n m=1
ends bootstrap

// POSH_TI_SAR_Parameterized/bootstrap_diff/schematic
I18 (VDD CLK net6 VSS) clk_doubler
I19 (VDD CLK net5 VSS) clk_doubler
I14 (VOUTP VDD VSS CLK CLKbar net6 INP) bootstrap
I10 (VOUTN VDD VSS CLK CLKbar net5 INN) bootstrap
simulatorOptions options temp=27
