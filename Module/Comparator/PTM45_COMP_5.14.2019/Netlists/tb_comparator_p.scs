// Design: POSH_TI_SAR_Parameterized/tb_comparator_p
simulator lang=spectre
global 0
parameters dif_pair=520n inv=180n inv_comp=180n latch_comp=180n nand_comp=180n nand_w=180n reset_comp=180n fcomp=100M vcm=550m VIN=0
include "/home/qiaochuz/workarea_ee536a/Techfile_45nm.scs"

// POSH_TI_SAR_Parameterized/NAND2/schematic
subckt NAND2 A B VDD VSS D
    M1 (net7 B VSS VSS) nmos w=nand_w l=45n m=20
    M0 (D A net7 VSS) nmos w=nand_w l=45n m=20
    M3 (D B VDD VDD) pmos w=26/9*nand_w l=45n m=10
    M2 (D A VDD VDD) pmos w=26/9*nand_w l=45n m=10
ends NAND2

// POSH_TI_SAR_Parameterized/inverter/schematic
subckt inverter VDD VIN VOUT VSS
    M0 (VOUT VIN VSS VSS) nmos w=inv l=45n m=10
    M1 (VOUT VIN VDD VDD) pmos w=26/9*inv l=45n m=10
ends inverter

// POSH_TI_SAR_Parameterized/NAND2_comp/schematic
subckt NAND2_comp A B VDD VSS D
    M1 (net7 B VSS VSS) nmos w=nand_comp l=45n m=20
    M0 (D A net7 VSS) nmos w=nand_comp l=45n m=20
    M3 (D B VDD VDD) pmos w=26/9*nand_comp l=45n m=10
    M2 (D A VDD VDD) pmos w=26/9*nand_comp l=45n m=10
ends NAND2_comp

// POSH_TI_SAR_Parameterized/comparator_p/schematic
subckt comparator_p CLKC RDY VDD VINN VINP VOUTN VOUTP VSS
    M10 (VOUTN net16 VSS VSS) nmos w=inv_comp l=45n m=10
    M3 (net16 net9 VSS VSS) nmos w=latch_comp l=45n m=10
    M5 (net16 CLKC VSS VSS) nmos w=reset_comp l=45n m=5
    M4 (net9 CLKC VSS VSS) nmos w=reset_comp l=45n m=5
    M7 (VOUTP net9 VSS VSS) nmos w=inv_comp l=45n m=10
    M6 (net9 net16 VSS VSS) nmos w=latch_comp l=45n m=10
    M9 (VOUTN net16 VDD VDD) pmos w=26/9*inv_comp l=45n m=10
    M0 (net12 CLKC VDD VDD) pmos w=2*dif_pair l=45n m=10
    M2 (net16 VINN net12 VDD) pmos w=dif_pair l=45n m=5
    M1 (net9 VINP net12 VDD) pmos w=dif_pair l=45n m=5
    M8 (VOUTP net9 VDD VDD) pmos w=26/9*inv_comp l=45n m=10
    I1 (VOUTP VOUTN VDD VSS RDY) NAND2_comp
ends comparator_p

// POSH_TI_SAR_Parameterized/tb_comparator_p/schematic
I17\<0\> (VOUTP VDD1 VDD1 VSS net013\<0\>) NAND2
I17\<1\> (VOUTP VDD1 VDD1 VSS net013\<1\>) NAND2
I17\<2\> (VOUTP VDD1 VDD1 VSS net013\<2\>) NAND2
I17\<3\> (VOUTP VDD1 VDD1 VSS net013\<3\>) NAND2
I17\<4\> (VOUTP VDD1 VDD1 VSS net013\<4\>) NAND2
I17\<5\> (VOUTP VDD1 VDD1 VSS net013\<5\>) NAND2
I17\<6\> (VOUTP VDD1 VDD1 VSS net013\<6\>) NAND2
I17\<7\> (VOUTP VDD1 VDD1 VSS net013\<7\>) NAND2
I18\<0\> (VOUTN VDD1 VDD1 VSS net014\<0\>) NAND2
I18\<1\> (VOUTN VDD1 VDD1 VSS net014\<1\>) NAND2
I18\<2\> (VOUTN VDD1 VDD1 VSS net014\<2\>) NAND2
I18\<3\> (VOUTN VDD1 VDD1 VSS net014\<3\>) NAND2
I18\<4\> (VOUTN VDD1 VDD1 VSS net014\<4\>) NAND2
I18\<5\> (VOUTN VDD1 VDD1 VSS net014\<5\>) NAND2
I18\<6\> (VOUTN VDD1 VDD1 VSS net014\<6\>) NAND2
I18\<7\> (VOUTN VDD1 VDD1 VSS net014\<7\>) NAND2
V5 (VDD1 0) vsource dc=1.1 type=dc
V4 (VINP 0) vsource dc=vcm+VIN/2 type=dc
V3 (VINN 0) vsource dc=vcm-VIN/2 type=dc
V1 (VSS 0) vsource dc=0 type=dc
V0 (VDD 0) vsource dc=1.1 type=dc
V2 (EN 0) vsource dc=0 type=pulse val0=0 val1=1.1 period=1/fcomp
I15\<0\> (VDD1 VOUTN net05\<0\> VSS) inverter
I15\<1\> (VDD1 VOUTN net05\<1\> VSS) inverter
I15\<2\> (VDD1 VOUTN net05\<2\> VSS) inverter
I15\<3\> (VDD1 VOUTN net05\<3\> VSS) inverter
I15\<4\> (VDD1 VOUTN net05\<4\> VSS) inverter
I15\<5\> (VDD1 VOUTN net05\<5\> VSS) inverter
I15\<6\> (VDD1 VOUTN net05\<6\> VSS) inverter
I15\<7\> (VDD1 VOUTN net05\<7\> VSS) inverter
I14\<0\> (VDD1 VOUTP net06\<0\> VSS) inverter
I14\<1\> (VDD1 VOUTP net06\<1\> VSS) inverter
I14\<2\> (VDD1 VOUTP net06\<2\> VSS) inverter
I14\<3\> (VDD1 VOUTP net06\<3\> VSS) inverter
I14\<4\> (VDD1 VOUTP net06\<4\> VSS) inverter
I14\<5\> (VDD1 VOUTP net06\<5\> VSS) inverter
I14\<6\> (VDD1 VOUTP net06\<6\> VSS) inverter
I14\<7\> (VDD1 VOUTP net06\<7\> VSS) inverter
I13\<0\> (VDD1 RDY net4\<0\> VSS) inverter
I13\<1\> (VDD1 RDY net4\<1\> VSS) inverter
I13\<2\> (VDD1 RDY net4\<2\> VSS) inverter
I13\<3\> (VDD1 RDY net4\<3\> VSS) inverter
I13\<4\> (VDD1 RDY net4\<4\> VSS) inverter
I13\<5\> (VDD1 RDY net4\<5\> VSS) inverter
I13\<6\> (VDD1 RDY net4\<6\> VSS) inverter
I13\<7\> (VDD1 RDY net4\<7\> VSS) inverter
I0 (EN RDY VDD VINN VINP VOUTN VOUTP VSS) comparator_p
simulatorOptions options temp=27
tran tran stop=400n errpreset=conservative noisefmax=100G noisefmin=1k noiseseed=1
save I0:3
