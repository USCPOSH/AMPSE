// Design: POSH_TI_SAR_Parameterized/comparator_p
simulator lang=spectre
global 0
parameters nand_comp inv_comp latch_comp reset_comp dif_pair

// POSH_TI_SAR_Parameterized/NAND2_comp/schematic
subckt NAND2_comp A B VDD VSS D
    M1 (net7 B VSS VSS) nmos w=nand_comp l=45n m=20
    M0 (D A net7 VSS) nmos w=nand_comp l=45n m=20
    M3 (D B VDD VDD) pmos w=26/9*nand_comp l=45n m=10
    M2 (D A VDD VDD) pmos w=26/9*nand_comp l=45n m=10
ends NAND2_comp

// POSH_TI_SAR_Parameterized/comparator_p/schematic
M10 (VOUTN net16 VSS VSS) nmos w=inv_comp l=45n m=10
M3 (net16 net9 VSS VSS) nmos w=latch_comp l=45n m=10
M5 (net16 CLKC VSS VSS) nmos w=reset_comp l=45n m=5
M4 (net9 CLKC VSS VSS) nmos w=reset_comp l=45n m=5
M7 (VOUTP net9 VSS VSS) nmos w=inv_comp l=45n m=10
M6 (net9 net16 VSS VSS) nmos w=latch_comp l=45n m=10
M9 (VOUTN net16 VDD VDD) pmos w=26/9*inv_comp l=45n m=10
M0 (net12 CLKC VDD VDD) pmos w=2*dif_pair l=45n m=10
M2 (net16 VINN net12 VDD) pmos w=dif_pair l=45n m=5
M1 (net9 VINP net12 VDD) pmos w=dif_pair l=45n m=5
M8 (VOUTP net9 VDD VDD) pmos w=26/9*inv_comp l=45n m=10
I1 (VOUTP VOUTN VDD VSS RDY) NAND2_comp
simulatorOptions options temp=27
