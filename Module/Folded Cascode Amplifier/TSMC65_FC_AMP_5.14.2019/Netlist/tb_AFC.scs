// Design: CAD_modules/test_ampfolded65
simulator lang=spectre
global 0
parameters vtn1=0.4 fn3=12 ln3=120n wn3=600n cl=1p rl=1G vcmin=0.6 vcmn=0.6 vcmo=1.0 vttt=0.5 fn1=12 fn2=12 fnt=12 fp1=60 fp2=60 ln1=120n ln2=120n lnt=200n lp1=120n lp2=120n vtn2=0.8 vtp2=0.25 wn1=600n wn2=600n wnt=600n wp1=600n wp2=600n

include "/home/mohsen/workarea_TSMC_MS_65_9M/tsmcN65_mc_shares.scs" section=MC_TT

// CAD_modules/test_ampfolded65/schematic
I13 (nin nip net019 net014 T TN TN2 TP TP2 VDD VSS) AMP_FOLDCASCODE65_v1
I12 (net027 net028 om op T TN TN2 TP TP2 VDD VSS) AMP_FOLDCASCODE65_v1
V11 (TN 0) vsource dc=vtn1 type=dc
V10 (TN2 0) vsource dc=vtn2 type=dc
V9 (TP2 0) vsource dc=vtp2 type=dc
V8 (net018 0) vsource dc=vcmin mag=1 phase=180 type=dc
V7 (net023 0) vsource dc=vcmin mag=1 phase=0 type=dc
V6 (cmn 0) vsource dc=vcmn type=dc
V5 (cmo 0) vsource dc=vcmo type=dc
V4 (T 0) vsource dc=vttt type=dc
V3 (net028 0) vsource dc=vcmin mag=0 phase=0 type=dc
V2 (net027 0) vsource dc=vcmin mag=1 phase=0 type=dc
V1 (VSS 0) vsource dc=0 type=dc
V0 (VDD 0) vsource dc=1 type=dc
C1 (VSS op) capacitor c=cl
C0 (VSS om) capacitor c=cl
R3 (net018 nip) resistor r=1K
R2 (net023 nin) resistor r=1K
R1 (cmn op) resistor r=rl
R0 (cmn om) resistor r=rl
E2 (TP VSS net012 cmo) vcvs gain=10 min=0 max=1
E1 (net012 net015 om VSS) vcvs gain=1.0
E0 (net015 VSS op VSS) vcvs gain=1.0
E3 (netout VSS op om) vcvs gain=1.0

simulatorOptions options temp=27
dcOp dc
ac ac start=1k stop=1T
noise ( om op ) noise start=1k stop=1T iprobe=V2 annotate=status

simulator lang=spice
.MEAS AC AVDD MAX VDB(netout) From=1k To=1T
.MEAS AC AVCM FIND VDB(net012) AT=100k
.MEAS AC GBW WHEN VDB(netout)=0
.MEAS AC ZBWWW WHEN VDB(nin)=-3
.MEAS NOISE outnoise INTEG 'ONOISE*ONOISE' FROM=1k To=1T
.MEAS DC swing PARAM='vds(I12.M5)-vdsat(I12.M5)-vds(I12.M11)+vdsat(I12.M11)'
.MEAS AC CIN1 par('1/(zbwww*6280)')
.MEAS DC pwr PARAM='-ids(I12.M10)-ids(I12.M9)'
