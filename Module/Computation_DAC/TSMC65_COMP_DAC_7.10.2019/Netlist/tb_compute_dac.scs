simulator lang = spectre
global 0
parameters
	Cu W_SW Cload T VDD=1 VSS=0
subckt RR_INVX1 A VDD VSS Y
	M0 ( Y A VDD VDD ) pmos l=60n w=260.0n nf=1
	M1 ( Y A VSS VSS ) nmos l=60n w=195.00n nf=1
ends RR_INVX1
subckt RR_NAND2_HVT A1 A2 VDD VSS ZN
	M10 ( ZN A2 net017 VSS ) nmos l=60n w=195.00n nf=1
	M8 ( net017 A1 VSS VSS ) nmos l=60n w=195.00n nf=1
	M5 ( ZN A2 VDD VDD ) pmos l=60n w=260.0n nf=1
	M4 ( ZN A1 VDD VDD ) pmos l=60n w=260.0n nf=1
ends RR_NAND2_HVT
subckt RR_BIT_CELL MEM MEM_B VDD VSS
	M128 ( MEM_B MEM VSS VSS ) nmos l=60n w=195.00n nf=1
	M123 ( MEM MEM_B VSS VSS ) nmos l=60n w=195.00n nf=1
	M125 ( MEM MEM_B VDD VDD ) pmos l=60n w=260.0n nf=1
	M130 ( MEM_B MEM VDD VDD ) pmos l=60n w=260.0n nf=1
ends RR_BIT_CELL
subckt RR_TR_GATE_V3_AMPSE C CB IN OUT VDD VSS
	M1 ( IN CB OUT VDD ) pmos l=60n w=260.0n multi=1 nf=1 sigma=1
	M2 ( IN C OUT VSS ) nmos l=60n w=195.00n multi=1 nf=1 sigma=1
ends RR_TR_GATE_V3_AMPSE
subckt RR_1BIT_CELL_COMPUTE_V5_AMPSE COMPUTE IN SL SL_B VDD VSS
	C1 ( SL_B net011 ) capacitor c=Cu
	C0 ( SL net010 ) capacitor c=Cu
	inv1 ( IN_B VDD VSS IN_BUF ) RR_INVX1
	nand ( IN COMPUTE VDD VSS IN_B ) RR_NAND2_HVT
	M0 ( net011 IN_B VSS VSS ) nmos l=60n w=W_SW*8 multi=1 nf=8 sigma=1
	sw3 ( net010 IN_B VSS VSS ) nmos l=60n w=W_SW*8 multi=1 nf=8 sigma=1
	I1 ( MEM MEM_B VDD VSS ) RR_BIT_CELL
	I78 ( IN_BUF IN_B MEM_B net011 VDD VSS ) RR_TR_GATE_V3_AMPSE
	I77 ( IN_BUF IN_B MEM net010 VDD VSS ) RR_TR_GATE_V3_AMPSE
ends RR_1BIT_CELL_COMPUTE_V5_AMPSE
	vss ( VSS 0 ) vsource dc=VSS type=dc
	vdd ( VDD 0 ) vsource dc=VDD type=dc
	I315 ( REFRESH REFRESH_B ) not_gate vlogic_high=1 vlogic_low=0 vtrans=0.5 tdel=20p trise=20p tfall=20p
	C0 ( VSS SL ) capacitor c=Cload
	C1 ( VSS SL_B ) capacitor c=Cload
	I1\<31\> ( COMPUTE IN\<31\> SL SL_B VDD VSS ) RR_1BIT_CELL_COMPUTE_V5_AMPSE
	I1\<30\> ( COMPUTE IN\<30\> SL SL_B VDD VSS ) RR_1BIT_CELL_COMPUTE_V5_AMPSE
	I1\<29\> ( COMPUTE IN\<29\> SL SL_B VDD VSS ) RR_1BIT_CELL_COMPUTE_V5_AMPSE
	I1\<28\> ( COMPUTE IN\<28\> SL SL_B VDD VSS ) RR_1BIT_CELL_COMPUTE_V5_AMPSE
	I1\<27\> ( COMPUTE IN\<27\> SL SL_B VDD VSS ) RR_1BIT_CELL_COMPUTE_V5_AMPSE
	I1\<26\> ( COMPUTE IN\<26\> SL SL_B VDD VSS ) RR_1BIT_CELL_COMPUTE_V5_AMPSE
	I1\<25\> ( COMPUTE IN\<25\> SL SL_B VDD VSS ) RR_1BIT_CELL_COMPUTE_V5_AMPSE
	I1\<24\> ( COMPUTE IN\<24\> SL SL_B VDD VSS ) RR_1BIT_CELL_COMPUTE_V5_AMPSE
	I1\<23\> ( COMPUTE IN\<23\> SL SL_B VDD VSS ) RR_1BIT_CELL_COMPUTE_V5_AMPSE
	I1\<22\> ( COMPUTE IN\<22\> SL SL_B VDD VSS ) RR_1BIT_CELL_COMPUTE_V5_AMPSE
	I1\<21\> ( COMPUTE IN\<21\> SL SL_B VDD VSS ) RR_1BIT_CELL_COMPUTE_V5_AMPSE
	I1\<20\> ( COMPUTE IN\<20\> SL SL_B VDD VSS ) RR_1BIT_CELL_COMPUTE_V5_AMPSE
	I1\<19\> ( COMPUTE IN\<19\> SL SL_B VDD VSS ) RR_1BIT_CELL_COMPUTE_V5_AMPSE
	I1\<18\> ( COMPUTE IN\<18\> SL SL_B VDD VSS ) RR_1BIT_CELL_COMPUTE_V5_AMPSE
	I1\<17\> ( COMPUTE IN\<17\> SL SL_B VDD VSS ) RR_1BIT_CELL_COMPUTE_V5_AMPSE
	I1\<16\> ( COMPUTE IN\<16\> SL SL_B VDD VSS ) RR_1BIT_CELL_COMPUTE_V5_AMPSE
	I1\<15\> ( COMPUTE IN\<15\> SL SL_B VDD VSS ) RR_1BIT_CELL_COMPUTE_V5_AMPSE
	I1\<14\> ( COMPUTE IN\<14\> SL SL_B VDD VSS ) RR_1BIT_CELL_COMPUTE_V5_AMPSE
	I1\<13\> ( COMPUTE IN\<13\> SL SL_B VDD VSS ) RR_1BIT_CELL_COMPUTE_V5_AMPSE
	I1\<12\> ( COMPUTE IN\<12\> SL SL_B VDD VSS ) RR_1BIT_CELL_COMPUTE_V5_AMPSE
	I1\<11\> ( COMPUTE IN\<11\> SL SL_B VDD VSS ) RR_1BIT_CELL_COMPUTE_V5_AMPSE
	I1\<10\> ( COMPUTE IN\<10\> SL SL_B VDD VSS ) RR_1BIT_CELL_COMPUTE_V5_AMPSE
	I1\<9\> ( COMPUTE IN\<9\> SL SL_B VDD VSS ) RR_1BIT_CELL_COMPUTE_V5_AMPSE
	I1\<8\> ( COMPUTE IN\<8\> SL SL_B VDD VSS ) RR_1BIT_CELL_COMPUTE_V5_AMPSE
	I1\<7\> ( COMPUTE IN\<7\> SL SL_B VDD VSS ) RR_1BIT_CELL_COMPUTE_V5_AMPSE
	I1\<6\> ( COMPUTE IN\<6\> SL SL_B VDD VSS ) RR_1BIT_CELL_COMPUTE_V5_AMPSE
	I1\<5\> ( COMPUTE IN\<5\> SL SL_B VDD VSS ) RR_1BIT_CELL_COMPUTE_V5_AMPSE
	I1\<4\> ( COMPUTE IN\<4\> SL SL_B VDD VSS ) RR_1BIT_CELL_COMPUTE_V5_AMPSE
	I1\<3\> ( COMPUTE IN\<3\> SL SL_B VDD VSS ) RR_1BIT_CELL_COMPUTE_V5_AMPSE
	I1\<2\> ( COMPUTE IN\<2\> SL SL_B VDD VSS ) RR_1BIT_CELL_COMPUTE_V5_AMPSE
	I1\<1\> ( COMPUTE IN\<1\> SL SL_B VDD VSS ) RR_1BIT_CELL_COMPUTE_V5_AMPSE
	I1\<0\> ( COMPUTE IN\<0\> SL SL_B VDD VSS ) RR_1BIT_CELL_COMPUTE_V5_AMPSE
	I3 ( REFRESH REFRESH_B SL_B VSS VDD VSS ) RR_TR_GATE_V3_AMPSE
	I2 ( REFRESH REFRESH_B SL VSS VDD VSS ) RR_TR_GATE_V3_AMPSE
	V8 ( COMPUTE 0 ) vsource dc=VSS type=pulse val0=VSS val1=VDD period=2*T delay=1.25*T rise=20p fall=20p width=0.6*T
	V6 ( REFRESH 0 ) vsource dc=VDD type=pulse val0=VDD val1=VSS period=2*T delay=T rise=20p fall=20p
simulatorOptions options reltol=1e-3 vabstol=1e-6 iabstol=1e-12 temp=27 \
    tnom=27 scalem=1.0 scale=1.0 gmin=1e-12 rforce=1 maxnotes=5 maxwarns=5 \
    digits=5 cols=80 pivrel=1e-3 sensfile="../psf/sens.output" \
    checklimitdest=psf
modelParameter info what=models where=rawfile
element info what=inst where=rawfile
outputParameter info what=output where=rawfile
designParamVals info what=parameters where=rawfile
primitives info what=primitives where=rawfile
subckts info what=subckts  where=rawfile
saveOptions options save=allpub
ahdl_include "/Cadence/IC615/tools/dfII/samples/artist/ahdlLib/not_gate/veriloga/veriloga.va"
