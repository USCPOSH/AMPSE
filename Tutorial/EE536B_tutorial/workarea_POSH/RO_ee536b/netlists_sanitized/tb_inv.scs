// Design: AMPSE_tutorial/tb_inv
simulator lang=spectre
global 0
parameters wn=100n wp=100n
include "/home/qiaochuz/workarea_ee536a/Techfile_45nm.scs"

// AMPSE_tutorial/inv/schematic
subckt inv gnd in out vdd
    M0 (out in vdd vdd) pmos w=wp l=45n
    M1 (out in gnd gnd) nmos w=wn l=45n
ends inv

// AMPSE_tutorial/tb_inv/schematic
I4 (gnd _net0 net04 vdd) inv
I1 (gnd _net1 _net0 vdd) inv
I0 (gnd net2 _net1 vdd) inv
V0 (net2 0) vsource type=pulse val0=1 val1=0 delay=1n rise=50p fall=50p
V2 (gnd 0) vsource dc=0 type=dc
V1 (vdd 0) vsource dc=1 type=dc
simulatorOptions options temp=27
tran tran stop=2n errpreset=conservative

export delay=oceanEval("cross(v(\"_net0\" ?result \"tran\" ?resultsDir \"/home/qiaochuz/workarea_POSH/RO_ee536b/temp/tb_inv/test.raw\") 0.5 1 \"falling\" nil nil)-cross(v(\"_net1\" ?result \"tran\" ?resultsDir \"/home/qiaochuz/workarea_POSH/RO_ee536b/temp/tb_inv/test.raw\") 0.5 1 \"rising\" nil nil)")
