simulator lang = spectre
global 0
parameters l_sw_cas w_sw_cas l_cs w_cs l_sw w_sw l_cs_cas w_cs_cas l_sw_driver w_sw_driver m_sw_driver l_cs_driver w_cs_driver m_cs_driver R_driver
include "/shares/techfile/TSMC_MS_65_9M/tsmcN65/../models/spectre/crn65gplus_2d5_lk_v1d0.scs" section = tt_bip
include "/shares/techfile/TSMC_MS_65_9M/tsmcN65/../models/spectre/crn65gplus_2d5_lk_v1d0.scs" section = tt_dio
include "/shares/techfile/TSMC_MS_65_9M/tsmcN65/../models/spectre/crn65gplus_2d5_lk_v1d0.scs" section = tt_dio_33
include "/shares/techfile/TSMC_MS_65_9M/tsmcN65/../models/spectre/crn65gplus_2d5_lk_v1d0.scs" section = tt_mim
include "/shares/techfile/TSMC_MS_65_9M/tsmcN65/../models/spectre/crn65gplus_2d5_lk_v1d0.scs" section = tt_dio_dnw
include "/shares/techfile/TSMC_MS_65_9M/tsmcN65/../models/spectre/crn65gplus_2d5_lk_v1d0.scs" section = tt_dio_18
include "/shares/techfile/TSMC_MS_65_9M/tsmcN65/../models/spectre/crn65gplus_2d5_lk_v1d0.scs" section = tt_bip_npn
include "/shares/techfile/TSMC_MS_65_9M/tsmcN65/../models/spectre/crn65gplus_2d5_lk_v1d0.scs" section = tt_33
include "/shares/techfile/TSMC_MS_65_9M/tsmcN65/../models/spectre/crn65gplus_2d5_lk_v1d0.scs" section = tt_rfrtmom
include "/shares/techfile/TSMC_MS_65_9M/tsmcN65/../models/spectre/crn65gplus_2d5_lk_v1d0.scs" section = tt_mos_cap_25
include "/shares/techfile/TSMC_MS_65_9M/tsmcN65/../models/spectre/crn65gplus_2d5_lk_v1d0.scs" section = tt_18
include "/shares/techfile/TSMC_MS_65_9M/tsmcN65/../models/spectre/crn65gplus_2d5_lk_v1d0.scs" section = tt_disres
include "/shares/techfile/TSMC_MS_65_9M/tsmcN65/../models/spectre/crn65gplus_2d5_lk_v1d0.scs" section = tt_res
include "/shares/techfile/TSMC_MS_65_9M/tsmcN65/../models/spectre/crn65gplus_2d5_lk_v1d0.scs" section = tt_dio_na
include "/shares/techfile/TSMC_MS_65_9M/tsmcN65/../models/spectre/crn65gplus_2d5_lk_v1d0.scs" section = tt_rfmos_33
include "/shares/techfile/TSMC_MS_65_9M/tsmcN65/../models/spectre/crn65gplus_2d5_lk_v1d0.scs" section = tt_dio_hvt
include "/shares/techfile/TSMC_MS_65_9M/tsmcN65/../models/spectre/crn65gplus_2d5_lk_v1d0.scs" section = tt_rfmvar
include "/shares/techfile/TSMC_MS_65_9M/tsmcN65/../models/spectre/crn65gplus_2d5_lk_v1d0.scs" section = tt_rfmos_18
include "/shares/techfile/TSMC_MS_65_9M/tsmcN65/../models/spectre/crn65gplus_2d5_lk_v1d0.scs" section = tt_na
include "/shares/techfile/TSMC_MS_65_9M/tsmcN65/../models/spectre/crn65gplus_2d5_lk_v1d0.scs" section = tt_dio_na33
include "/shares/techfile/TSMC_MS_65_9M/tsmcN65/../models/spectre/crn65gplus_2d5_lk_v1d0.scs" section = tt_dio_lvt
include "/shares/techfile/TSMC_MS_65_9M/tsmcN65/../models/spectre/crn65gplus_2d5_lk_v1d0.scs" section = tt_rfres_sa
include "/shares/techfile/TSMC_MS_65_9M/tsmcN65/../models/spectre/crn65gplus_2d5_lk_v1d0.scs" section = tt_na33
include "/shares/techfile/TSMC_MS_65_9M/tsmcN65/../models/spectre/crn65gplus_2d5_lk_v1d0.scs" section = tt_dio_esd
include "/shares/techfile/TSMC_MS_65_9M/tsmcN65/../models/spectre/crn65gplus_2d5_lk_v1d0.scs" section = tt_rfmim
include "/shares/techfile/TSMC_MS_65_9M/tsmcN65/../models/spectre/crn65gplus_2d5_lk_v1d0.scs" section = tt_dio_25od33
include "/shares/techfile/TSMC_MS_65_9M/tsmcN65/../models/spectre/crn65gplus_2d5_lk_v1d0.scs" section = tt_25od33
include "/shares/techfile/TSMC_MS_65_9M/tsmcN65/../models/spectre/crn65gplus_2d5_lk_v1d0.scs" section = tt
include "/shares/techfile/TSMC_MS_65_9M/tsmcN65/../models/spectre/crn65gplus_2d5_lk_v1d0.scs" section = tt_mos_cap
include "/shares/techfile/TSMC_MS_65_9M/tsmcN65/../models/spectre/crn65gplus_2d5_lk_v1d0.scs" section = tt_dio_25
include "/shares/techfile/TSMC_MS_65_9M/tsmcN65/../models/spectre/crn65gplus_2d5_lk_v1d0.scs" section = tt_dio_25ud18
include "/shares/techfile/TSMC_MS_65_9M/tsmcN65/../models/spectre/crn65gplus_2d5_lk_v1d0.scs" section = tt_25
include "/shares/techfile/TSMC_MS_65_9M/tsmcN65/../models/spectre/crn65gplus_2d5_lk_v1d0.scs" section = tt_rfmos
include "/shares/techfile/TSMC_MS_65_9M/tsmcN65/../models/spectre/crn65gplus_2d5_lk_v1d0.scs" section = tt_25ud18
include "/shares/techfile/TSMC_MS_65_9M/tsmcN65/../models/spectre/crn65gplus_2d5_lk_v1d0.scs" section = tt_dio_na25od33
include "/shares/techfile/TSMC_MS_65_9M/tsmcN65/../models/spectre/crn65gplus_2d5_lk_v1d0.scs" section = tt_rfjvar
include "/shares/techfile/TSMC_MS_65_9M/tsmcN65/../models/spectre/crn65gplus_2d5_lk_v1d0.scs" section = tt_rfmos_25
include "/shares/techfile/TSMC_MS_65_9M/tsmcN65/../models/spectre/crn65gplus_2d5_lk_v1d0.scs" section = tt_rtmom
include "/shares/techfile/TSMC_MS_65_9M/tsmcN65/../models/spectre/crn65gplus_2d5_lk_v1d0.scs" section = tt_na25od33
include "/shares/techfile/TSMC_MS_65_9M/tsmcN65/../models/spectre/crn65gplus_2d5_lk_v1d0.scs" section = tt_dio_na25
include "/shares/techfile/TSMC_MS_65_9M/tsmcN65/../models/spectre/crn65gplus_2d5_lk_v1d0.scs" section = tt_rfres_rpo
include "/shares/techfile/TSMC_MS_65_9M/tsmcN65/../models/spectre/crn65gplus_2d5_lk_v1d0.scs" section = tt_hvt
include "/shares/techfile/TSMC_MS_65_9M/tsmcN65/../models/spectre/crn65gplus_2d5_lk_v1d0.scs" section = tt_rfind
include "/shares/techfile/TSMC_MS_65_9M/tsmcN65/../models/spectre/crn65gplus_2d5_lk_v1d0.scs" section = tt_rfmvar_25
include "/shares/techfile/TSMC_MS_65_9M/tsmcN65/../models/spectre/crn65gplus_2d5_lk_v1d0.scs" section = tt_na25
include "/shares/techfile/TSMC_MS_65_9M/tsmcN65/../models/spectre/crn65gplus_2d5_lk_v1d0.scs" section = tt_lvt
subckt cs_1 MSB_cas_d MSB_cur_d MSB_vbias_sn MSB_vbias_sp gnd inn inp ncas ncur_MSB outn outp vbias vdd
	M0 ( outn vbias MSB_vbias_sn gnd ) nmos l=l_sw_cas w=w_sw_cas*2 multi=1 nf=2 sigma=1
	M7 ( outp vbias MSB_vbias_sp gnd ) nmos l=l_sw_cas w=w_sw_cas*2 multi=1 nf=2 sigma=1
	M16 ( net018 ncur_MSB gnd gnd ) nmos l=l_cs w=w_cs*30 multi=1 nf=30 sigma=1
	M18 ( vdd inn net017 gnd ) nmos l=l_sw w=w_sw*30 multi=1 nf=30 sigma=1
	M17 ( net017 ncas net018 gnd ) nmos l=l_cs_cas w=w_cs_cas*30 multi=1 nf=30 sigma=1
	M19 ( vdd inp net017 gnd ) nmos l=l_sw w=w_sw*30 multi=1 nf=30 sigma=1
	M15 ( MSB_vbias_sp inp MSB_cas_d gnd ) nmos l=l_sw w=w_sw*2 multi=1 nf=2 sigma=1
	M14 ( MSB_vbias_sn inn MSB_cas_d gnd ) nmos l=l_sw w=w_sw*2 multi=1 nf=2 sigma=1
	LSB1_tail ( MSB_cas_d ncas MSB_cur_d gnd ) nmos l=l_cs_cas w=w_cs_cas*2 multi=1 nf=2 sigma=1
	MSB_tail ( MSB_cur_d ncur_MSB gnd gnd ) nmos l=l_cs w=w_cs*2 multi=1 nf=2 sigma=1
ends cs_1
subckt cs_2 MSB_cas_d MSB_cur_d MSB_vbias_sn MSB_vbias_sp gnd inn inp ncas ncur_MSB outn outp vbias vdd
	M0 ( outn vbias MSB_vbias_sn gnd ) nmos l=l_sw_cas w=w_sw_cas*4 multi=1 nf=4 sigma=1
	M7 ( outp vbias MSB_vbias_sp gnd ) nmos l=l_sw_cas w=w_sw_cas*4 multi=1 nf=4 sigma=1
	M16 ( net018 ncur_MSB gnd gnd ) nmos l=l_cs w=w_cs*28 multi=1 nf=28 sigma=1
	M18 ( vdd inn net017 gnd ) nmos l=l_sw w=w_sw*28 multi=1 nf=28 sigma=1
	M17 ( net017 ncas net018 gnd ) nmos l=l_cs_cas w=w_cs_cas*28 multi=1 nf=28 sigma=1
	M19 ( vdd inp net017 gnd ) nmos l=l_sw w=w_sw*28 multi=1 nf=28 sigma=1
	M15 ( MSB_vbias_sp inp MSB_cas_d gnd ) nmos l=l_sw w=w_sw*4 multi=1 nf=4 sigma=1
	M14 ( MSB_vbias_sn inn MSB_cas_d gnd ) nmos l=l_sw w=w_sw*4 multi=1 nf=4 sigma=1
	LSB1_tail ( MSB_cas_d ncas MSB_cur_d gnd ) nmos l=l_cs_cas w=w_cs_cas*4 multi=1 nf=4 sigma=1
	MSB_tail ( MSB_cur_d ncur_MSB gnd gnd ) nmos l=l_cs w=w_cs*4 multi=1 nf=4 sigma=1
ends cs_2
subckt cs_4 MSB_cas_d MSB_cur_d MSB_vbias_sn MSB_vbias_sp gnd inn inp ncas ncur_MSB outn outp vbias vdd
	M0 ( outn vbias MSB_vbias_sn gnd ) nmos l=l_sw_cas w=w_sw_cas*8 multi=1 nf=8 sigma=1
	M7 ( outp vbias MSB_vbias_sp gnd ) nmos l=l_sw_cas w=w_sw_cas*8 multi=1 nf=8 sigma=1
	M17 ( net017 ncas net018 gnd ) nmos l=l_cs_cas w=w_cs_cas*24 multi=1 nf=24 sigma=1
	M18 ( vdd inn net017 gnd ) nmos l=l_sw w=w_sw*24 multi=1 nf=24 sigma=1
	M16 ( net018 ncur_MSB gnd gnd ) nmos l=l_cs w=w_cs*24 multi=1 nf=24 sigma=1
	M19 ( vdd inp net017 gnd ) nmos l=l_sw w=w_sw*24 multi=1 nf=24 sigma=1
	M15 ( MSB_vbias_sp inp MSB_cas_d gnd ) nmos l=l_sw w=w_sw*8 multi=1 nf=8 sigma=1
	M14 ( MSB_vbias_sn inn MSB_cas_d gnd ) nmos l=l_sw w=w_sw*8 multi=1 nf=8 sigma=1
	LSB1_tail ( MSB_cas_d ncas MSB_cur_d gnd ) nmos l=l_cs_cas w=w_cs_cas*8 multi=1 nf=8 sigma=1
	MSB_tail ( MSB_cur_d ncur_MSB gnd gnd ) nmos l=l_cs w=w_cs*8 multi=1 nf=8 sigma=1
ends cs_4
subckt cs_8 MSB_cas_d MSB_cur_d MSB_vbias_sn MSB_vbias_sp gnd inn inp ncas ncur_MSB outn outp vbias vdd
	M0 ( outn vbias MSB_vbias_sn gnd ) nmos l=l_sw_cas w=w_sw_cas*16 multi=1 nf=16 sigma=1
	M7 ( outp vbias MSB_vbias_sp gnd ) nmos l=l_sw_cas w=w_sw_cas*16 multi=1 nf=16 sigma=1
	M19 ( vdd inp net28 gnd ) nmos l=l_sw w=w_sw*16 multi=1 nf=16 sigma=1
	M18 ( vdd inn net28 gnd ) nmos l=l_sw w=w_sw*16 multi=1 nf=16 sigma=1
	M17 ( net28 ncas net29 gnd ) nmos l=l_cs_cas w=w_cs_cas*16 multi=1 nf=16 sigma=1
	M16 ( net29 ncur_MSB gnd gnd ) nmos l=l_cs w=w_cs*16 multi=1 nf=16 sigma=1
	M15 ( MSB_vbias_sp inp MSB_cas_d gnd ) nmos l=l_sw w=w_sw*16 multi=1 nf=16 sigma=1
	M14 ( MSB_vbias_sn inn MSB_cas_d gnd ) nmos l=l_sw w=w_sw*16 multi=1 nf=16 sigma=1
	LSB1_tail ( MSB_cas_d ncas MSB_cur_d gnd ) nmos l=l_cs_cas w=w_cs_cas*16 multi=1 nf=16 sigma=1
	MSB_tail ( MSB_cur_d ncur_MSB gnd gnd ) nmos l=l_cs w=w_cs*16 multi=1 nf=16 sigma=1
ends cs_8
subckt cs_16 MSB_cas_d MSB_cur_d MSB_vbias_sn MSB_vbias_sp gnd inn inp ncas ncur_MSB outn outp vbias
	M0 ( outn vbias MSB_vbias_sn gnd ) nmos l=l_sw_cas w=w_sw_cas*32 multi=1 nf=32 sigma=1
	M7 ( outp vbias MSB_vbias_sp gnd ) nmos l=l_sw_cas w=w_sw_cas*32 multi=1 nf=32 sigma=1
	M15 ( MSB_vbias_sp inp MSB_cas_d gnd ) nmos l=l_sw w=w_sw*32 multi=1 nf=32 sigma=1
	M14 ( MSB_vbias_sn inn MSB_cas_d gnd ) nmos l=l_sw w=w_sw*32 multi=1 nf=32 sigma=1
	LSB1_tail ( MSB_cas_d ncas MSB_cur_d gnd ) nmos l=l_cs_cas w=w_cs_cas*32 multi=1 nf=32 sigma=1
	MSB_tail ( MSB_cur_d ncur_MSB gnd gnd ) nmos l=l_cs w=w_cs*32 multi=1 nf=32 sigma=1
ends cs_16
subckt cs_array_8b gnd inn_lsb\<3\> inn_lsb\<2\> inn_lsb\<1\> inn_lsb\<0\> inn_msb\<14\> inn_msb\<13\> inn_msb\<12\> inn_msb\<11\> inn_msb\<10\> inn_msb\<9\> inn_msb\<8\> inn_msb\<7\> inn_msb\<6\> inn_msb\<5\> inn_msb\<4\> inn_msb\<3\> inn_msb\<2\> inn_msb\<1\> inn_msb\<0\> inp_lsb\<3\> inp_lsb\<2\> inp_lsb\<1\> inp_lsb\<0\> inp_msb\<14\> inp_msb\<13\> inp_msb\<12\> inp_msb\<11\> inp_msb\<10\> inp_msb\<9\> inp_msb\<8\> inp_msb\<7\> inp_msb\<6\> inp_msb\<5\> inp_msb\<4\> inp_msb\<3\> inp_msb\<2\> inp_msb\<1\> inp_msb\<0\> outn_lsb\<3\> outn_lsb\<2\> outn_lsb\<1\> outn_lsb\<0\> outn_msb\<14\> outn_msb\<13\> outn_msb\<12\> outn_msb\<11\> outn_msb\<10\> outn_msb\<9\> outn_msb\<8\> outn_msb\<7\> outn_msb\<6\> outn_msb\<5\> outn_msb\<4\> outn_msb\<3\> outn_msb\<2\> outn_msb\<1\> outn_msb\<0\> outp_lsb\<3\> outp_lsb\<2\> outp_lsb\<1\> outp_lsb\<0\> outp_msb\<14\> outp_msb\<13\> outp_msb\<12\> outp_msb\<11\> outp_msb\<10\> outp_msb\<9\> outp_msb\<8\> outp_msb\<7\> outp_msb\<6\> outp_msb\<5\> outp_msb\<4\> outp_msb\<3\> outp_msb\<2\> outp_msb\<1\> outp_msb\<0\> vbias_cs vbias_cs_cas vbias_sw_cas vdd
	I0 ( net4 net3 net1 net2 gnd inn_lsb\<0\> inp_lsb\<0\> vbias_cs_cas vbias_cs outn_lsb\<0\> outp_lsb\<0\> vbias_sw_cas vdd ) cs_1
	I10 ( net01 net02 net04 net03 gnd inn_lsb\<1\> inp_lsb\<1\> vbias_cs_cas vbias_cs outn_lsb\<1\> outp_lsb\<1\> vbias_sw_cas vdd ) cs_2
	I15 ( net09 net010 net012 net011 gnd inn_lsb\<2\> inp_lsb\<2\> vbias_cs_cas vbias_cs outn_lsb\<2\> outp_lsb\<2\> vbias_sw_cas vdd ) cs_4
	I20 ( net05 net06 net08 net07 gnd inn_lsb\<3\> inp_lsb\<3\> vbias_cs_cas vbias_cs outn_lsb\<3\> outp_lsb\<3\> vbias_sw_cas vdd ) cs_8
	I25\<14\> ( net021\<0\> net024\<0\> net023\<0\> net022\<0\> gnd inn_msb\<14\> inp_msb\<14\> vbias_cs_cas vbias_cs outn_msb\<14\> outp_msb\<14\> vbias_sw_cas ) cs_16
	I25\<13\> ( net021\<1\> net024\<1\> net023\<1\> net022\<1\> gnd inn_msb\<13\> inp_msb\<13\> vbias_cs_cas vbias_cs outn_msb\<13\> outp_msb\<13\> vbias_sw_cas ) cs_16
	I25\<12\> ( net021\<2\> net024\<2\> net023\<2\> net022\<2\> gnd inn_msb\<12\> inp_msb\<12\> vbias_cs_cas vbias_cs outn_msb\<12\> outp_msb\<12\> vbias_sw_cas ) cs_16
	I25\<11\> ( net021\<3\> net024\<3\> net023\<3\> net022\<3\> gnd inn_msb\<11\> inp_msb\<11\> vbias_cs_cas vbias_cs outn_msb\<11\> outp_msb\<11\> vbias_sw_cas ) cs_16
	I25\<10\> ( net021\<4\> net024\<4\> net023\<4\> net022\<4\> gnd inn_msb\<10\> inp_msb\<10\> vbias_cs_cas vbias_cs outn_msb\<10\> outp_msb\<10\> vbias_sw_cas ) cs_16
	I25\<9\> ( net021\<5\> net024\<5\> net023\<5\> net022\<5\> gnd inn_msb\<9\> inp_msb\<9\> vbias_cs_cas vbias_cs outn_msb\<9\> outp_msb\<9\> vbias_sw_cas ) cs_16
	I25\<8\> ( net021\<6\> net024\<6\> net023\<6\> net022\<6\> gnd inn_msb\<8\> inp_msb\<8\> vbias_cs_cas vbias_cs outn_msb\<8\> outp_msb\<8\> vbias_sw_cas ) cs_16
	I25\<7\> ( net021\<7\> net024\<7\> net023\<7\> net022\<7\> gnd inn_msb\<7\> inp_msb\<7\> vbias_cs_cas vbias_cs outn_msb\<7\> outp_msb\<7\> vbias_sw_cas ) cs_16
	I25\<6\> ( net021\<8\> net024\<8\> net023\<8\> net022\<8\> gnd inn_msb\<6\> inp_msb\<6\> vbias_cs_cas vbias_cs outn_msb\<6\> outp_msb\<6\> vbias_sw_cas ) cs_16
	I25\<5\> ( net021\<9\> net024\<9\> net023\<9\> net022\<9\> gnd inn_msb\<5\> inp_msb\<5\> vbias_cs_cas vbias_cs outn_msb\<5\> outp_msb\<5\> vbias_sw_cas ) cs_16
	I25\<4\> ( net021\<10\> net024\<10\> net023\<10\> net022\<10\> gnd inn_msb\<4\> inp_msb\<4\> vbias_cs_cas vbias_cs outn_msb\<4\> outp_msb\<4\> vbias_sw_cas ) cs_16
	I25\<3\> ( net021\<11\> net024\<11\> net023\<11\> net022\<11\> gnd inn_msb\<3\> inp_msb\<3\> vbias_cs_cas vbias_cs outn_msb\<3\> outp_msb\<3\> vbias_sw_cas ) cs_16
	I25\<2\> ( net021\<12\> net024\<12\> net023\<12\> net022\<12\> gnd inn_msb\<2\> inp_msb\<2\> vbias_cs_cas vbias_cs outn_msb\<2\> outp_msb\<2\> vbias_sw_cas ) cs_16
	I25\<1\> ( net021\<13\> net024\<13\> net023\<13\> net022\<13\> gnd inn_msb\<1\> inp_msb\<1\> vbias_cs_cas vbias_cs outn_msb\<1\> outp_msb\<1\> vbias_sw_cas ) cs_16
	I25\<0\> ( net021\<14\> net024\<14\> net023\<14\> net022\<14\> gnd inn_msb\<0\> inp_msb\<0\> vbias_cs_cas vbias_cs outn_msb\<0\> outp_msb\<0\> vbias_sw_cas ) cs_16
ends cs_array_8b
subckt cs_driver_cml gnd in inb out outb vbias vdd
	MP2b ( out inb net7 gnd ) nmos l=l_sw_driver w=w_sw_driver*m_sw_driver multi=1 nf=m_sw_driver sigma=1
	MP2 ( outb in net7 gnd ) nmos l=l_sw_driver w=w_sw_driver*m_sw_driver multi=1 nf=m_sw_driver sigma=1
	slave_driver_cs ( net7 vbias gnd gnd ) nmos l=l_cs_driver w=w_cs_driver*m_cs_driver multi=1 nf=m_cs_driver sigma=1
	R1 ( vdd out ) resistor r=R_driver
	R0 ( vdd outb ) resistor r=R_driver
ends cs_driver_cml
	I30 ( gnd inn_lsb_m\<3\> inn_lsb_m\<2\> inn_lsb_m\<1\> inn_lsb_m\<0\> inn_msb_m\<14\> inn_msb_m\<13\> inn_msb_m\<12\> inn_msb_m\<11\> inn_msb_m\<10\> inn_msb_m\<9\> inn_msb_m\<8\> inn_msb_m\<7\> inn_msb_m\<6\> inn_msb_m\<5\> inn_msb_m\<4\> inn_msb_m\<3\> inn_msb_m\<2\> inn_msb_m\<1\> inn_msb_m\<0\> inp_lsb_m\<3\> inp_lsb_m\<2\> inp_lsb_m\<1\> inp_lsb_m\<0\> inp_msb_m\<14\> inp_msb_m\<13\> inp_msb_m\<12\> inp_msb_m\<11\> inp_msb_m\<10\> inp_msb_m\<9\> inp_msb_m\<8\> inp_msb_m\<7\> inp_msb_m\<6\> inp_msb_m\<5\> inp_msb_m\<4\> inp_msb_m\<3\> inp_msb_m\<2\> inp_msb_m\<1\> inp_msb_m\<0\> outn_lsb\<3\> outn_lsb\<2\> outn_lsb\<1\> outn_lsb\<0\> outn_msb\<14\> outn_msb\<13\> outn_msb\<12\> outn_msb\<11\> outn_msb\<10\> outn_msb\<9\> outn_msb\<8\> outn_msb\<7\> outn_msb\<6\> outn_msb\<5\> outn_msb\<4\> outn_msb\<3\> outn_msb\<2\> outn_msb\<1\> outn_msb\<0\> outp_lsb\<3\> outp_lsb\<2\> outp_lsb\<1\> outp_lsb\<0\> outp_msb\<14\> outp_msb\<13\> outp_msb\<12\> outp_msb\<11\> outp_msb\<10\> outp_msb\<9\> outp_msb\<8\> outp_msb\<7\> outp_msb\<6\> outp_msb\<5\> outp_msb\<4\> outp_msb\<3\> outp_msb\<2\> outp_msb\<1\> outp_msb\<0\> vbias_cs vbias_cs_cas vbias_sw_cas vdd ) cs_array_8b
	I31\<18\> ( gnd inp_msb\<14\> inn_msb\<14\> inp_msb_m\<14\> inn_msb_m\<14\> vbias_cs_driver vdd ) cs_driver_cml
	I31\<17\> ( gnd inp_msb\<13\> inn_msb\<13\> inp_msb_m\<13\> inn_msb_m\<13\> vbias_cs_driver vdd ) cs_driver_cml
	I31\<16\> ( gnd inp_msb\<12\> inn_msb\<12\> inp_msb_m\<12\> inn_msb_m\<12\> vbias_cs_driver vdd ) cs_driver_cml
	I31\<15\> ( gnd inp_msb\<11\> inn_msb\<11\> inp_msb_m\<11\> inn_msb_m\<11\> vbias_cs_driver vdd ) cs_driver_cml
	I31\<14\> ( gnd inp_msb\<10\> inn_msb\<10\> inp_msb_m\<10\> inn_msb_m\<10\> vbias_cs_driver vdd ) cs_driver_cml
	I31\<13\> ( gnd inp_msb\<9\> inn_msb\<9\> inp_msb_m\<9\> inn_msb_m\<9\> vbias_cs_driver vdd ) cs_driver_cml
	I31\<12\> ( gnd inp_msb\<8\> inn_msb\<8\> inp_msb_m\<8\> inn_msb_m\<8\> vbias_cs_driver vdd ) cs_driver_cml
	I31\<11\> ( gnd inp_msb\<7\> inn_msb\<7\> inp_msb_m\<7\> inn_msb_m\<7\> vbias_cs_driver vdd ) cs_driver_cml
	I31\<10\> ( gnd inp_msb\<6\> inn_msb\<6\> inp_msb_m\<6\> inn_msb_m\<6\> vbias_cs_driver vdd ) cs_driver_cml
	I31\<9\> ( gnd inp_msb\<5\> inn_msb\<5\> inp_msb_m\<5\> inn_msb_m\<5\> vbias_cs_driver vdd ) cs_driver_cml
	I31\<8\> ( gnd inp_msb\<4\> inn_msb\<4\> inp_msb_m\<4\> inn_msb_m\<4\> vbias_cs_driver vdd ) cs_driver_cml
	I31\<7\> ( gnd inp_msb\<3\> inn_msb\<3\> inp_msb_m\<3\> inn_msb_m\<3\> vbias_cs_driver vdd ) cs_driver_cml
	I31\<6\> ( gnd inp_msb\<2\> inn_msb\<2\> inp_msb_m\<2\> inn_msb_m\<2\> vbias_cs_driver vdd ) cs_driver_cml
	I31\<5\> ( gnd inp_msb\<1\> inn_msb\<1\> inp_msb_m\<1\> inn_msb_m\<1\> vbias_cs_driver vdd ) cs_driver_cml
	I31\<4\> ( gnd inp_msb\<0\> inn_msb\<0\> inp_msb_m\<0\> inn_msb_m\<0\> vbias_cs_driver vdd ) cs_driver_cml
	I31\<3\> ( gnd inp_lsb\<3\> inn_lsb\<3\> inp_lsb_m\<3\> inn_lsb_m\<3\> vbias_cs_driver vdd ) cs_driver_cml
	I31\<2\> ( gnd inp_lsb\<2\> inn_lsb\<2\> inp_lsb_m\<2\> inn_lsb_m\<2\> vbias_cs_driver vdd ) cs_driver_cml
	I31\<1\> ( gnd inp_lsb\<1\> inn_lsb\<1\> inp_lsb_m\<1\> inn_lsb_m\<1\> vbias_cs_driver vdd ) cs_driver_cml
	I31\<0\> ( gnd inp_lsb\<0\> inn_lsb\<0\> inp_lsb_m\<0\> inn_lsb_m\<0\> vbias_cs_driver vdd ) cs_driver_cml
simulatorOptions options reltol=1e-3 vabstol=1e-6 iabstol=1e-12 temp=27 \
    tnom=27 multithread=on nthreads=4 scalem=1.0 scale=1.0 gmin=1e-12 \
    rforce=1 maxnotes=5 maxwarns=5 digits=5 cols=80 pivrel=1e-3 \
    sensfile="../psf/sens.output" checklimitdest=psf
modelParameter info what=models where=rawfile
element info what=inst where=rawfile
outputParameter info what=output where=rawfile
designParamVals info what=parameters where=rawfile
primitives info what=primitives where=rawfile
subckts info what=subckts where=rawfile
saveOptions options save=allpub
