simulator( 'spectre )
design(	 "/home/shiyusu1/workarea_TSMC65_9M/simulation/tb_cs_array_8b/spectre/schematic/netlist/netlist")
resultsDir( "/home/shiyusu1/workarea_TSMC65_9M/simulation/tb_cs_array_8b/spectre/schematic" )
modelFile(
    '("/home/shiyusu1/workarea_TSMC65_9M/tsmcN65_mc_shares.scs" "TT")
)
analysis('tran ?stop "210n"  ?errpreset "moderate"  )
desVar(	  "vbias_SW_cas" 1.86	)
desVar(	  "vbias_cs_cas" 749.7m	)
desVar(	  "vbias_cs" 404.3m	)
desVar(	  "v_swing" 250m	)
desVar(	  "l_cs" 685n	)
desVar(	  "l_cs_cas" 120n	)
desVar(	  "l_sw" 60n	)
desVar(	  "l_sw_cas" 280n	)
desVar(	  "w_cs" 2u	)
desVar(	  "w_cs_cas" 375n	)
desVar(	  "w_sw" 560n	)
desVar(	  "w_sw_cas" 400n	)
desVar(	  "adcfullscal" 1	)
desVar(	  "amp_sine" 0.499	)
desVar(	  "freq_sine" 9.015G	)
desVar(	  "fs" 20G	)
desVar(	  "os_sine" 0.5	)
desVar(	  "tfall" 10p	)
desVar(	  "trise" 10p	)
desVar(	  "vdd" 1	)
desVar(	  "v_high" 1	)
desVar(	  "R" 25	)
envOption(
	'cmd64bit  t
	'analysisOrder  list("tran")
)
option( ?categ 'turboOpts
	'uniMode  "APS"
)
saveOption( ?simOutputFormat "sst2" )
saveOption( 'save "selected" )
save( 'v "/DACoutn" "/DACoutp" "/vdd_cell" )
save( 'i "/V0/PLUS" "/V4/MINUS" "/R0/MINUS" )
temp( 27 )
run()
DAC_out = (VT("/DACoutn") - VT("/DACoutp"))
pwr = abs(average((VT("/vdd_cell") * IT("/V0/PLUS"))))
plot( pwr ?expr '( "pwr" ) )
SFDR\(\-HD3\) = (value(db20(dft(DAC_out 1e-08 2.1e-07 100000 "Rectangular" 0 0 1)) 9.015e+09) - value(db20(dft(DAC_out 1e-08 2.1e-07 100000 "Rectangular" 0 0 1)) 7.045e+09))
plot( SFDR\(\-HD3\) ?expr '( "SFDR(-HD3)" ) )
i_fullscale = (ymax((IT("/V4/MINUS") - IT("/R0/MINUS"))) - ymin((IT("/V4/MINUS") - IT("/R0/MINUS"))))
plot( i_fullscale ?expr '( "i_fullscale" ) )
