simulator( 'spectre )
design(	 "/home/shiyusu1/workarea_TSMC65_9M/simulation/tb_cs_driver_cml/spectre/schematic/netlist/netlist")
resultsDir( "/home/shiyusu1/workarea_TSMC65_9M/simulation/tb_cs_driver_cml/spectre/schematic" )
modelFile(
    '("/shares/shiyusu1/workarea_TSMC65_9M/tsmcN65_mc_shares.scs" "TT")
)
analysis('tran ?stop "1n"  ?errpreset "moderate"  )
desVar(	  "l_cs_driver" 400n	)
desVar(	  "l_sw_driver" 60n	)
desVar(	  "m_cs_driver" 12	)
desVar(	  "m_sw_driver" 20	)
desVar(	  "w_cs_driver" 8u	)
desVar(	  "w_sw_driver" 3u	)
desVar(	  "fs" 20G	)
desVar(	  "l_cs" 685n	)
desVar(	  "l_cs_cas" 120n	)
desVar(	  "l_sw" 60n	)
desVar(	  "l_sw_cas" 280n	)
desVar(	  "R_driver" 50	)
desVar(	  "tfall" 10p	)
desVar(	  "trise" 10p	)
desVar(	  "v_swing" 400m	)
desVar(	  "vbias" 0.4	)
desVar(	  "vdd" 1	)
desVar(	  "w_cs" 2u	)
desVar(	  "w_cs_cas" 375n	)
desVar(	  "w_sw" 560n	)
desVar(	  "w_sw_cas" 400n	)
envOption(
	'analysisOrder  list("tran")
)
option( ?categ 'turboOpts
	'uniMode  "APS"
)
save( 'i "/V0/PLUS" )
temp( 27 )
run()
selectResult( 'tran )
plot(getData("/in") getData("/inb") getData("/outb") getData("/out") )
output_swing = (ymax(VT("/out")) - ymin(VT("/out")))
plot( output_swing ?expr '( "output_swing" ) )
pwr = abs(average((IT("/V0/PLUS") * VT("/vdd"))))
plot( pwr ?expr '( "pwr" ) )
fall_time = fallTime(VT("/out") ymax(VT("/out")) nil ymin(VT("/out")) nil 25 85 nil "time")
plot( fall_time ?expr '( "fall_time" ) )
rise_time = riseTime(VT("/out") ymin(VT("/out")) nil ymax(VT("/out")) nil 25 85 nil "time")
plot( rise_time ?expr '( "rise_time" ) )
