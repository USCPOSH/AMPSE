simulator( 'spectre )
design(	 "/home/shiyusu1/workarea_TSMC65_9M/simulation/tb_CS_DAC/spectre/schematic/netlist/netlist")
resultsDir( "/home/shiyusu1/workarea_TSMC65_9M/simulation/tb_CS_DAC/spectre/schematic" )
modelFile(
    '("/home/shiyusu1/workarea_TSMC65_9M/tsmcN65_mc_shares.scs" "TT")
)
analysis('tran ?stop "210n"  ?errpreset "moderate"  )
desVar(	  "l_cs_driver" 382.2n	)
desVar(	  "l_sw_driver" 60n	)
desVar(	  "m_cs_driver" 12	)
desVar(	  "m_sw_driver" 20	)
desVar(	  "R_driver" 48.34	)
desVar(	  "vbias_cs_driver" 369.8m	)
desVar(	  "w_cs_driver" 8.431u	)
desVar(	  "w_sw_driver" 3u	)
desVar(	  "vbias_SW_cas" 1.896	)
desVar(	  "vbias_cs_cas" 749.7m	)
desVar(	  "vbias_cs" 404.3m	)
desVar(	  "v_swing" 297.5m	)
desVar(	  "l_cs" 746.1n	)
desVar(	  "l_cs_cas" 120n	)
desVar(	  "l_sw" 60n	)
desVar(	  "l_sw_cas" 280n	)
desVar(	  "w_cs" 1.035u	)
desVar(	  "w_cs_cas" 375n	)
desVar(	  "w_sw" 396.8n	)
desVar(	  "w_sw_cas" 400n	)
desVar(	  "adcfullscal" 1	)
desVar(	  "amp_sine" 0.499	)
desVar(	  "freq_sine" 9.015G	)
desVar(	  "fs" 20G	)
desVar(	  "os_sine" 0.5	)
desVar(	  "tfall" 10p	)
desVar(	  "trise" 10p	)
desVar(	  "vdd" 1	)
desVar(	  "v_high" 1	)
desVar(	  "R" 25	)
envOption(
	'cmd64bit  t
	'analysisOrder  list("tran")
)
option( ?categ 'turboOpts
	'uniMode  "APS"
)
saveOption( ?simOutputFormat "sst2" )
saveOption( 'save "selected" )
save( 'v "/DACoutn" "/DACoutp" "/vdd_cell" "/I20/inp_msb_m<14,0,1>" )
save( 'i "/V0/PLUS" "/V4/MINUS" "/R0/MINUS" "/I20/vdd" )
temp( 27 )
run()
selectResult( 'tran )
plot(getData("/V4/MINUS") getData("/R0/MINUS") getData("/I20/inp_msb_m<14,0,1>") getData("/I20/vdd") )
DAC_out = (VT("/DACoutn") - VT("/DACoutp"))
plot( DAC_out ?expr '( "DAC_out" ) )
pwr = abs(average((VT("/vdd_cell") * IT("/V0/PLUS"))))
plot( pwr ?expr '( "pwr" ) )
SFDR\(\-HD3\) = (value(db20(dft(DAC_out 1e-08 2.1e-07 100000 "Rectangular" 0 0 1)) 9.015e+09) - value(db20(dft(DAC_out 1e-08 2.1e-07 100000 "Rectangular" 0 0 1)) 7.045e+09))
plot( SFDR\(\-HD3\) ?expr '( "SFDR(-HD3)" ) )
i_fullscale = (ymax((IT("/V4/MINUS") - IT("/R0/MINUS"))) - ymin((IT("/V4/MINUS") - IT("/R0/MINUS"))))
plot( i_fullscale ?expr '( "i_fullscale" ) )
